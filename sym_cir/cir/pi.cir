R1 in n1   1k
C1 n1 gnd 10n
R3 n1 out 1k
C3 out gnd 10n
