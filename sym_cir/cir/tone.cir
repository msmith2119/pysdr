R1 in 3 3.3k
R2 4 0 330
R3 8 out 1k
P1 3 8 4 10k 0.5
P2 7 2 5 10k 0.5
C1 8 3 47n
C2 8 4 470n
C3 7 1 10n
C4 5 0 100n
