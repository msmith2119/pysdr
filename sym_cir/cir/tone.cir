R1 in 3 3.3
R2 4 gnd 330
R3 8 out  1
P1 3 8 4 0.01 a1
P2 7 out 5 0.01 a2
C1 8 3 0.000047
C2 8 4  0.00047
C3 7 in 0.00001
C4 5 gnd 0.0001
